ADE simulation setup
Run mode: Single Run, Sweeps and Corners
Tests:
  lab4_FrequencySelectiveCircuits:BSF:1: lab4_FrequencySelectiveCircuits/BSF/schematic, simulator spectre
    Outputs: /net1
