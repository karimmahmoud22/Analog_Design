ADE simulation setup
Run mode: Single Run, Sweeps and Corners
Tests:
  Lab5_Diode_Karim:exp4:1: Lab5_Diode_Karim/exp4/schematic, simulator spectre
    Outputs: /net1; /net2
