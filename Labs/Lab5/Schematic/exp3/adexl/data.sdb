ADE simulation setup
Run mode: Single Run, Sweeps and Corners
Tests:
  Lab5_Diode_Karim:exp3:1: Lab5_Diode_Karim/exp3/schematic, simulator spectre
    Outputs: /net3; /net2; /net1
