ADE simulation setup
Run mode: Single Run, Sweeps and Corners
Tests:
  Lab5_Diode_Karim:assignment:1: Lab5_Diode_Karim/assignment/schematic, simulator spectre
    Outputs: /V0/PLUS; /D1/MINUS; /C1/PLUS; /C0/PLUS; /net3; /net2; /net1; /net4
