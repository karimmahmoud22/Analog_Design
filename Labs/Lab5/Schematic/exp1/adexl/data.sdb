ADE simulation setup
Run mode: Single Run, Sweeps and Corners
Tests:
  Lab5_Diode_Karim:exp1:1: Lab5_Diode_Karim/exp1/schematic, simulator spectre
