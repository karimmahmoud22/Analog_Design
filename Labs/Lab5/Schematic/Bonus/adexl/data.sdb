ADE simulation setup
Run mode: Single Run, Sweeps and Corners
Tests:
  Lab5_Diode_Karim:Bonus:1: Lab5_Diode_Karim/Bonus/schematic, simulator spectre
    Outputs: /net3; /net1
