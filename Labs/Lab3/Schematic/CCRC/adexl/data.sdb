ADE simulation setup
Run mode: Single Run, Sweeps and Corners
Tests:
  lab3:CCRC:1: lab3/CCRC/schematic, simulator spectre
