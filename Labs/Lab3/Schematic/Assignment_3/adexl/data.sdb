ADE simulation setup
Run mode: Single Run, Sweeps and Corners
Tests:
  lab3:Assignment_3:1: lab3/Assignment_3/schematic, simulator spectre
