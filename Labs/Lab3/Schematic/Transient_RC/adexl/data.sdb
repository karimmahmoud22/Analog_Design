ADE simulation setup
Run mode: Single Run, Sweeps and Corners
Tests:
  lab3:Transient_RC:1: lab3/Transient_RC/schematic, simulator spectre
