ADE simulation setup
Run mode: Single Run, Sweeps and Corners
Tests:
  lab3:Transient_RLC:1: lab3/Transient_RLC/schematic, simulator spectre
