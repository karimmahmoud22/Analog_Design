ADE simulation setup
Run mode: Single Run, Sweeps and Corners
Tests:
  lab3:Transient_LC:1: lab3/Transient_LC/schematic, simulator spectre
