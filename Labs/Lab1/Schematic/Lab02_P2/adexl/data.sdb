ADE simulation setup
Run mode: Single Run, Sweeps and Corners
Tests:
  CND_Sec15:Lab02_P2:1: CND_Sec15/Lab02_P2/schematic, simulator spectre
