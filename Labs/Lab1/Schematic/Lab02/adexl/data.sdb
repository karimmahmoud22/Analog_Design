ADE simulation setup
Run mode: Single Run, Sweeps and Corners
Tests:
  CND_Sec15:Lab02:1: CND_Sec15/Lab02/schematic, simulator spectre
    Outputs: /R2/PLUS; /R6/PLUS; /net8
Global variables:
  RL = 2k
  Ru = 4k
  Vdc = 15
  Rth = 6k
